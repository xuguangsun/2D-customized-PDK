// VerilogA for MoS2, Mo, veriloga

`include "constants.vams"
`include "disciplines.vams"
//`define Vmin 10e-6 //Vmin [V] should be about 2-4 times the absolute tolerance for voltage of the simulator
module NMo(D, G, S);

inout D, G, S;

electrical D, G, S, dx, sx, di, gi, si;

//`define attr(txt) (*txt*)

parameter real L     = 0.5u     from [0 :inf];// channel length" unit="um"
parameter real W     = 30.0u     from [0.0:inf];//    channel width" unit="um"
parameter real MU    = 1.00 from [0.0:inf];//   Mobility at extraction voltage VAA" unit="cm2/VS"
parameter real COX   = 5.6e-7 from [0.0:inf];// gate capacitance" unit="F/cm2");160e-9
parameter real COL   = 0 from [0.0:1e-6];// fringe cap in gate fF/um
parameter real CGSD  = 1e-12 from [0.0:1e-6];// Gate S/D cap fF/um^2
parameter real COLGSD= 0 from [0.0:1e-6];//
parameter real CSD   = 0 from [0.0:1e-6];// S/D cap
parameter real VTO   = -1.3     from [-inf:inf];// long channel threshold voltage" unit="V" 0.5
parameter integer FLG_SPLT = 1 from [0:1];// Flag for split gate design or not'
parameter integer FINGER =1 from[1:1000];// Matrix transistor finger num
parameter real sdW = 0.25u from[0:25];//S/D width um
parameter real gsdEnc = 2.5u from[-1e-9:10];//gate S/D enclosure um
parameter real gcntEnc = 1.0e-9 from[-1e-9:20];//gate cnt enclosure um
parameter real TEMP  = 300.0  from [0:500];// circuit temperature" unit="Kelvin"
parameter real LAMBDA= 0.01      from [0.0:inf];// channel length modulation" unit="1/V
parameter real VSS   = 0.25    from [-inf:inf];// STHS parameter" unit="V"
parameter real GAMMA = 2   from [-inf:inf];//  voltage exponent -2" unit=""
parameter real IOFF  = -1e-12 from [-inf:inf];//   `attr(info="off current" unit="A");
parameter real MM    = 1.65   from [1e-5:inf];// info="transistion parameter" unit=""
parameter real AA    = 1.0      from [1e-5:inf];// info="transistion parameter" unit=""

parameter real SLOPE    = 10.0      from [1e-5:inf];// Capacitance Interpolation slope;
parameter real VAA   = 1.0      from [-inf:inf];// Extraction voltage for mobility MU" unit="V
parameter real RCS= 10       from [0.0:inf];// default 1.05e3 source contact resistance" unit="Ohm
parameter real RCD= 10       from [0.0:inf];// drain contact resistance" unit="Ohm"
parameter integer FLG_FLD = 0   from [0:1];// Flag for VGS dependent VD-induced field" unit=""

// parameters for parasitics

parameter real RFS= 1       from [0.0:inf];// `attr(info="source finger resistance" unit="Ohm");
parameter real RFD= 1       from [0.0:inf];// `attr(info="drain finger resistance" unit="Ohm");
parameter real RFG= 1       from [0.0:inf];// `attr(info="gate finger resistance" unit="Ohm");

// parameters for type

parameter integer typep=1 from [-1:1] exclude 0;// channel type" unit="" //1=electron, -1=hole

real VGeff, VDeff, VDfld, VDfld2, VSeff, VSfld, VSfld2, VDsub, VSsub, Isd, Ids, Ids2, VG, VS, VD, Vds,VDSe, Vgs, sVsd, VDe, VSe, vt, b, c;
real gmin;

real Qd, Qs;
real Itest;
real area_gcnt;//
real perip_gcnt;//
real area_gsd;//
real perip_gsd;//
real COXG;// unit F
real CPGS;
real CPGD;// parasitic gate-drain capacitance" unit="F"
real CPDS;// "parasitic drain-source capacitance" unit="F"
real CPG,CGS,CGD;// gate capacitance

analog begin
// Layout Based Gate Capacitanc
//W = w;
//L = l;
if (FLG_SPLT==1) begin
area_gcnt = FINGER*W*(L+2*gsdEnc);//
perip_gcnt = FINGER*2*(W+L+2*gsdEnc);//
area_gsd = FINGER*4*gsdEnc*gcntEnc;//
perip_gsd = FINGER*4*(gsdEnc+2*gcntEnc);//
COXG = COX*1e4;// unit F/um^2
CPG=area_gcnt*COXG;
CPGS = area_gsd*COXG/2+perip_gcnt*COL/2+perip_gsd*COLGSD/2 ;// "parasitic gate-source capacitance" unit="F");
CPGD = CPGS;// `attr(info="parasitic gate-drain capacitance" unit="F");
CPDS = FINGER*W*CSD;// `attr(info="parasitic drain-source capacitance" unit="F");
end else begin
area_gcnt = W*(FINGER*(L+sdW)-sdW+2*gsdEnc);//
perip_gcnt = 2*(W+FINGER*(L+sdW)-sdW+2*gsdEnc);//
area_gsd = 4*gsdEnc*gcntEnc+2*(FINGER-1)*gcntEnc*sdW;//
perip_gsd = 4*(gsdEnc+2*gcntEnc)+(FINGER-1)*2*(sdW+2*gcntEnc);//
COXG = COX*1e4;// unit F/um^2
CPG=area_gcnt*COXG;
CPGS = area_gsd*COXG/2+perip_gcnt*COL/2+perip_gsd*COLGSD/2 ;// "parasitic gate-source capacitance" unit="F");
CPGD = CPGS;// `attr(info="parasitic gate-drain capacitance" unit="F");
CPDS = FINGER*W*CSD;// `attr(info="parasitic drain-source capacitance" unit="F");
end

VG    = V(gi);
VD    = V(di);
VS    = V(si);

if (VS-VD>=0) begin
    sVsd = 1.0;
    VSe = VS;//Vde is the  highest node
    VDe = VD;
end else begin
    sVsd = -1.0;
    VSe = VD;
    VDe = VS;
end

////////////////////////////////////////////////////////////////
/////   Current model    ///////////////////////////////////////
////////////////////////////////////////////////////////////////

VDfld = VDe;
VSfld = VSe;

if (typep*(VG-VTO-VDfld)/VSS<-10.0)
    VDsub = VSS*exp(typep*(VG-VTO-VDfld)/VSS);
else if (typep*(VG-VTO-VDfld)/VSS>100.0) begin
    VDsub = typep*(VG-VTO-VDfld);
end else begin
    VDsub = VSS*ln(1+exp(typep*(VG-VTO-VDfld)/VSS));end

if (typep*(VG-VTO-VSfld)/VSS<-10.0)
    VSsub = VSS*exp(typep*(VG-VTO-VSfld)/VSS);
else if (typep*(VG-VTO-VSfld)/VSS>100.0) begin
    VSsub = typep*(VG-VTO-VSfld);
end else begin
    VSsub = VSS*ln(1+exp(typep*(VG-VTO-VSfld)/VSS)); end

/////////////////////////////////////////////////////////////
////////////Dynamic Meyer's Cap Model///////////////////////
if(sVsd==1) begin
CGS= CPG*(2/3*(1-pow(VDsub,2)/pow((VDsub+VSsub),2)));
CGD = CPG*(2/3*(1-pow(VSsub,2)/pow((VDsub+VSsub),2)));
end else begin
CGD = CPG*(2/3*(1-pow(VDsub,2)/pow((VDsub+VSsub),2)));
CGS = CPG*(2/3*(1-pow(VSsub,2)/pow((VDsub+VSsub),2)));
end
Qs = CGS*(VSsub);
Qd = CGD*(VSsub);
///////////////////////////////////////////////////////////
//////////////P type CNT-TFT Current Model/////////////////
Isd=IOFF + FINGER*W/L*MU/pow(VAA,GAMMA)*COX*(pow(VSsub,GAMMA+2.0)-pow(VDsub,GAMMA+2.0))/(GAMMA+2.0)*(1.0+LAMBDA*abs(VDe-VSe));
if (abs(VD-VS)<1e-12)
      Isd=0.0;
////////////////////////////////////////////////////////////////
/////   Circuit elements   /////////////////////////////////////
////////////////////////////////////////////////////////////////CGD*CGS*
// Transfer current
I(di,si) <+ typep*sVsd*Isd;

gmin = 1e-14; //needed to improve convergence
I(di,si) <+ gmin*V(di,si);

    I(si,sx) <+ V(si,sx)/(RCS);
    I(di,dx) <+ V(di,dx)/(RCD);
    I(S,sx) <+ V(S,sx)/(RFS);
    I(D,dx) <+ V(D,dx)/(RFD);
    I(G,gi) <+ V(G,gi)/(RFG);

I(gi,di) <+ ddt(Qd);
I(gi,si) <+ ddt(Qs);
// parasitic finger capacitance
I(gi,dx) <+ CPGD*ddt(V(gi,dx));
I(gi,sx) <+ CPGS*ddt(V(gi,sx));
I(dx,sx) <+ CPDS*ddt(V(dx,sx));

end endmodule
