ADE simulation setup
Run mode: Single Run, Sweeps and Corners
Tests:
  MoS2_MoS2Inv_pseudo_E_1: MoS2/MoS2Inv_pseudo_E/config, simulator spectre
    Variables: M2_w = 10u; a = 0
