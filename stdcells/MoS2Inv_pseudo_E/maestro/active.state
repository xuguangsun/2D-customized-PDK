ADE simulation setup
Test MoS2_MoS2Inv_pseudo_E_1: MoS2/MoS2Inv_pseudo_E/config, simulator spectre
  Models: /home/xuguang/virtuosoworkspace/workspace/FHEPDK/gpdk045_v_6_0/gpdk045/../models/spectre/gpdk045.scs[mc]
  Variables: M2_w = 10u; a = 0
  Temperature: 27
  Files: DSPF \  
  Analysis tran: stop=1u
  Signals: /VIN, /VOUT
Run mode: Single Run, Sweeps and Corners
