; 1um Mo technology
; Pcell MoS2/Mo/layout generated by GTE Version: 03.05.003  Build: @1662 (20140701024425) on Oct 16, 2024

let((gteLibName gteCellName gteViewName gteLibObjSpec gteCDF gteDbId)

    ; set default lib/cell/view names
    gteLibName="MoS2"
    gteCellName="Mo"
    gteViewName="layout"

    ; override lib/cell/view if they were set by PasSetLibObjSpec
    when( isCallable('PasGetLibObjSpec)
        when( gteLibObjSpec=PasGetLibObjSpec()
            gteLibName=gteLibObjSpec->libName || gteLibName
            gteCellName=gteLibObjSpec->cellName || gteCellName
            gteViewName=gteLibObjSpec->viewName || gteViewName
        )
    )

    unless(gteCDF=cdfGetBaseCellCDF(ddGetObj(gteLibName gteCellName))
        error("pcDefinePCell %s/%s: base CDF not defined " gteLibName gteCellName)
    )

    gteDbId=pcDefinePCell(

        list(ddGetObj(gteLibName) gteCellName gteViewName "maskLayout")

        ;pcell parameters
        (
            (fingers float
                case(gteCDF~>fingers~>paramType
                    (nil error("pcDefinePCell %s/%s: CDF parameter fingers not defined" gteLibName gteCellName))
                    ("float" gteCDF~>fingers~>defValue)
                    (("string" "cyclic")
                        if( gteCDF~>fingers~>parseAsNumber then
                            cdfParseFloatString(gteCDF~>fingers~>defValue)
                        else
                            error("pcDefinePCell %s/%s: CDF parameter fingers does not parse as number" gteLibName gteCellName)
                        )
                    )
                    (t error("pcDefinePCell %s/%s: CDF parameter fingers incompatible type" gteLibName gteCellName))
                )
            )
            (Overlap float
                case(gteCDF~>Overlap~>paramType
                    (nil error("pcDefinePCell %s/%s: CDF parameter Overlap not defined" gteLibName gteCellName))
                    ("float" gteCDF~>Overlap~>defValue)
                    (("string" "cyclic")
                        if( gteCDF~>Overlap~>parseAsNumber then
                            cdfParseFloatString(gteCDF~>Overlap~>defValue)
                        else
                            error("pcDefinePCell %s/%s: CDF parameter Overlap does not parse as number" gteLibName gteCellName)
                        )
                    )
                    (t error("pcDefinePCell %s/%s: CDF parameter Overlap incompatible type" gteLibName gteCellName))
                )
            )
            (deltay float 0)
            (deltax float 0)
            (L float
                case(gteCDF~>L~>paramType
                    (nil error("pcDefinePCell %s/%s: CDF parameter L not defined" gteLibName gteCellName))
                    ("float" gteCDF~>L~>defValue)
                    (("string" "cyclic")
                        if( gteCDF~>L~>parseAsNumber then
                            cdfParseFloatString(gteCDF~>L~>defValue)
                        else
                            error("pcDefinePCell %s/%s: CDF parameter L does not parse as number" gteLibName gteCellName)
                        )
                    )
                    (t error("pcDefinePCell %s/%s: CDF parameter L incompatible type" gteLibName gteCellName))
                )
            )
            (W float
                case(gteCDF~>W~>paramType
                    (nil error("pcDefinePCell %s/%s: CDF parameter W not defined" gteLibName gteCellName))
                    ("float" gteCDF~>W~>defValue)
                    (("string" "cyclic")
                        if( gteCDF~>W~>parseAsNumber then
                            cdfParseFloatString(gteCDF~>W~>defValue)
                        else
                            error("pcDefinePCell %s/%s: CDF parameter W does not parse as number" gteLibName gteCellName)
                        )
                    )
                    (t error("pcDefinePCell %s/%s: CDF parameter W incompatible type" gteLibName gteCellName))
                )
            )
            (wpf float
                case(gteCDF~>wpf~>paramType
                    (nil error("pcDefinePCell %s/%s: CDF parameter wpf not defined" gteLibName gteCellName))
                    ("float" gteCDF~>wpf~>defValue)
                    (("string" "cyclic")
                        if( gteCDF~>wpf~>parseAsNumber then
                            cdfParseFloatString(gteCDF~>wpf~>defValue)
                        else
                            error("pcDefinePCell %s/%s: CDF parameter wpf does not parse as number" gteLibName gteCellName)
                        )
                    )
                    (t error("pcDefinePCell %s/%s: CDF parameter wpf incompatible type" gteLibName gteCellName))
                )
            )
            (PDEXT float
                case(gteCDF~>PDEXT~>paramType
                    (nil error("pcDefinePCell %s/%s: CDF parameter PDEXT not defined" gteLibName gteCellName))
                    ("float" gteCDF~>PDEXT~>defValue)
                    (("string" "cyclic")
                        if( gteCDF~>PDEXT~>parseAsNumber then
                            cdfParseFloatString(gteCDF~>PDEXT~>defValue)
                        else
                            error("pcDefinePCell %s/%s: CDF parameter PDEXT does not parse as number" gteLibName gteCellName)
                        )
                    )
                    (t error("pcDefinePCell %s/%s: CDF parameter PDEXT incompatible type" gteLibName gteCellName))
                )
            )
            (GAP float
                case(gteCDF~>GAP~>paramType
                    (nil error("pcDefinePCell %s/%s: CDF parameter GAP not defined" gteLibName gteCellName))
                    ("float" gteCDF~>GAP~>defValue)
                    (("string" "cyclic")
                        if( gteCDF~>GAP~>parseAsNumber then
                            cdfParseFloatString(gteCDF~>GAP~>defValue)
                        else
                            error("pcDefinePCell %s/%s: CDF parameter GAP does not parse as number" gteLibName gteCellName)
                        )
                    )
                    (t error("pcDefinePCell %s/%s: CDF parameter GAP incompatible type" gteLibName gteCellName))
                )
            )
            (ML float
                case(gteCDF~>ML~>paramType
                    (nil error("pcDefinePCell %s/%s: CDF parameter ML not defined" gteLibName gteCellName))
                    ("float" gteCDF~>ML~>defValue)
                    (("string" "cyclic")
                        if( gteCDF~>ML~>parseAsNumber then
                            cdfParseFloatString(gteCDF~>ML~>defValue)
                        else
                            error("pcDefinePCell %s/%s: CDF parameter ML does not parse as number" gteLibName gteCellName)
                        )
                    )
                    (t error("pcDefinePCell %s/%s: CDF parameter ML incompatible type" gteLibName gteCellName))
                )
            )
            (MW float
                case(gteCDF~>MW~>paramType
                    (nil error("pcDefinePCell %s/%s: CDF parameter MW not defined" gteLibName gteCellName))
                    ("float" gteCDF~>MW~>defValue)
                    (("string" "cyclic")
                        if( gteCDF~>MW~>parseAsNumber then
                            cdfParseFloatString(gteCDF~>MW~>defValue)
                        else
                            error("pcDefinePCell %s/%s: CDF parameter MW does not parse as number" gteLibName gteCellName)
                        )
                    )
                    (t error("pcDefinePCell %s/%s: CDF parameter MW incompatible type" gteLibName gteCellName))
                )
            )
            (NDEXT float
                case(gteCDF~>NDEXT~>paramType
                    (nil error("pcDefinePCell %s/%s: CDF parameter NDEXT not defined" gteLibName gteCellName))
                    ("float" gteCDF~>NDEXT~>defValue)
                    (("string" "cyclic")
                        if( gteCDF~>NDEXT~>parseAsNumber then
                            cdfParseFloatString(gteCDF~>NDEXT~>defValue)
                        else
                            error("pcDefinePCell %s/%s: CDF parameter NDEXT does not parse as number" gteLibName gteCellName)
                        )
                    )
                    (t error("pcDefinePCell %s/%s: CDF parameter NDEXT incompatible type" gteLibName gteCellName))
                )
            )
            (VL float
                case(gteCDF~>VL~>paramType
                    (nil error("pcDefinePCell %s/%s: CDF parameter VL not defined" gteLibName gteCellName))
                    ("float" gteCDF~>VL~>defValue)
                    (("string" "cyclic")
                        if( gteCDF~>VL~>parseAsNumber then
                            cdfParseFloatString(gteCDF~>VL~>defValue)
                        else
                            error("pcDefinePCell %s/%s: CDF parameter VL does not parse as number" gteLibName gteCellName)
                        )
                    )
                    (t error("pcDefinePCell %s/%s: CDF parameter VL incompatible type" gteLibName gteCellName))
                )
            )
            (VW float
                case(gteCDF~>VW~>paramType
                    (nil error("pcDefinePCell %s/%s: CDF parameter VW not defined" gteLibName gteCellName))
                    ("float" gteCDF~>VW~>defValue)
                    (("string" "cyclic")
                        if( gteCDF~>VW~>parseAsNumber then
                            cdfParseFloatString(gteCDF~>VW~>defValue)
                        else
                            error("pcDefinePCell %s/%s: CDF parameter VW does not parse as number" gteLibName gteCellName)
                        )
                    )
                    (t error("pcDefinePCell %s/%s: CDF parameter VW incompatible type" gteLibName gteCellName))
                )
            )
            (connectGates string
                case(gteCDF~>connectGates~>paramType
                    (nil error("pcDefinePCell %s/%s: CDF parameter connectGates not defined" gteLibName gteCellName))
                    (("string" "radio" "cyclic") gteCDF~>connectGates~>defValue)
                    (t error("pcDefinePCell %s/%s: CDF parameter connectGates incompatible type" gteLibName gteCellName))
                )
            )
            (connectSD boolean
                case(gteCDF~>connectSD~>paramType
                    (nil error("pcDefinePCell %s/%s: CDF parameter connectSD not defined" gteLibName gteCellName))
                    ("boolean" gteCDF~>connectSD~>defValue)
                    (t error("pcDefinePCell %s/%s: CDF parameter connectSD incompatible type" gteLibName gteCellName))
                )
            )
            (switchSD boolean
                case(gteCDF~>switchSD~>paramType
                    (nil error("pcDefinePCell %s/%s: CDF parameter switchSD not defined" gteLibName gteCellName))
                    ("boolean" gteCDF~>switchSD~>defValue)
                    (t error("pcDefinePCell %s/%s: CDF parameter switchSD incompatible type" gteLibName gteCellName))
                )
            )
        )

        ;pcell body
        let((cv tfId mfgGrid grid grid2 gteLabelId gteNetId gteTermId gtePinId
             gteWeakName gteMustName gteUniqueTermNum
             gteX gteY gteWidth gteLength gtePoint gteObj gteTmp gteMinx gteMiny gteMaxx gteMaxy
             gteContWidth gteContLength gteSpaceX gteSpaceY
             gteContWidth2 gteRefPoint gteRefX gteRefY gteList gteRadius gteLabelHeight
             gteWidtha gteWidthb gteRadiusX gteRadiusY gteChopa gteChopb gteNumSegs gteSpace
             gteTopRingWidth gteBottomRingWidth, gteLeftRingWidth, gteRightRingWidth
             gteSepInside gteSepOutside gteMaster gteMosaic
             gtePoints gteBBox gteInnerBBox
             gteShape0 gteShape1 gteShape2 gteShape3 gteShape4 gteShape5 gteShape6 gteShape7
             gteShape8 gteShape9 gteShape10 gteShape11 gteShape12 gteShape13 gteShape14 gteShape15
             gteShape16 gteShape17
            )

            cv=pcCellView
            tfId=techGetTechFile(cv)
            mfgGrid=techGetMfgGridResolution(tfId)
            if( mfgGrid then grid=mfgGrid else
                grid=0.005
                techSetMfgGridResolution(tfId grid)
            )
            grid2=grid/2.0

            gteUniqueTermNum=0

            L=L*1e6
            wpf=wpf*1e6
            W=wpf
            Overlap=Overlap*1e6
            PDEXT=PDEXT*1e6
            GAP=GAP*1e6
            ML=ML*1e6
            MW=MW*1e6
            NDEXT=NDEXT*1e6
            VL=VL*1e6
            VW=VW*1e6
            fingers=int(fingers)
            L=L+deltax

            for( i 1 fingers

                gteShape0=rodCreateRect(
                    ?name               get_pname(concat("m1" "_" i))
                    ?layer              list("Gate" "drawing")
                    ?width              L+2*Overlap
                    ?length             W+2*PDEXT+2*GAP+deltay
                )

                rodAlign(
                    ?alignObj           gteShape0
                    ?alignHandle        'lowerCenter
                    ?refPoint           list((10+MW)*(i-1)+NDEXT+GAP+MW+1 -10-GAP-PDEXT)
                )

                rodAssignHandleToParameter(
                    ?parameter          "deltay"
                    ?rodObj             gteShape0
                    ?handleName         'upperCenter
                    ?displayName        "deltay"
                    ?stretchDir         'y
                    ?stretchType        'relative
                    ?moveOrigin         nil
                    ?updateIncrement    0.1
                )

                rodAssignHandleToParameter(
                    ?parameter          "deltax"
                    ?rodObj             gteShape0
                    ?handleName         'centerRight
                    ?displayName        "deltax"
                    ?stretchDir         'x
                    ?stretchType        'relative
                    ?moveOrigin         nil
                    ?updateIncrement    0.1
                )

                rodAssignHandleToParameter(
                    ?parameter          "deltay"
                    ?rodObj             gteShape0
                    ?handleName         'lowerCenter
                    ?displayName        "deltay"
                    ?stretchDir         'y
                    ?stretchType        'relative
                    ?moveOrigin         t
                    ?updateIncrement    0.1
                )

                GTEaddIC6pin(cv gteShape0~>dbId "G" "inputOutput" "topgate" list("left" "right") nil nil gteUniqueTermNum++)

            ) ;end for

            for( i 1 fingers

                gteShape1=rodCreateRect(
                    ?name               get_pname(concat("p" "_" i))
                    ?layer              list("Mchannel" "drawing")
                    ?width              10+2*MW+2*GAP+2*NDEXT
                    ?length             W
                )

                rodAlign(
                    ?alignObj           gteShape1
                    ?alignHandle        'centerCenter
                    ?refObj             rodGetObj(get_pname(concat("m1" "_" i)))
                    ?refHandle          'centerCenter
                    ?maintain           nil
                )

            ) ;end for

            if( fingers == 1 then

                gteShape2=rodCreateRect(
                    ?name               get_pname(concat("m2" "_" 1))
                    ?layer              list("Metal3" "drawing")
                    ?width              MW+(10-L)/2
                    ?length             ML
                )

                rodAlign(
                    ?alignObj           gteShape2
                    ?alignHandle        'centerLeft
                    ?refObj             rodGetObj(get_pname(concat("p" "_" 1)))
                    ?refHandle          'centerLeft
                    ?xSep               NDEXT+GAP
                    ?maintain           nil
                )

                gteShape3=rodCreateRect(
                    ?name               get_pname(concat("m2" "_" 2))
                    ?layer              list("Metal3" "drawing")
                    ?width              MW+(10-L)/2
                    ?length             ML
                )

                rodAlign(
                    ?alignObj           gteShape3
                    ?alignHandle        'centerRight
                    ?refObj             rodGetObj(get_pname(concat("p" "_" 1)))
                    ?refHandle          'centerRight
                    ?xSep               minus(NDEXT+GAP)
                    ?maintain           nil
                )

            ) ;end if

            if( fingers>1 then

                gteShape4=rodCreateRect(
                    ?name               get_pname(concat("m2" "_" 1))
                    ?layer              list("Metal3" "drawing")
                    ?width              MW+(10-L)/2
                    ?length             ML
                )

                rodAlign(
                    ?alignObj           gteShape4
                    ?alignHandle        'centerLeft
                    ?refObj             rodGetObj(get_pname(concat("p" "_" 1)))
                    ?refHandle          'centerLeft
                    ?xSep               NDEXT+GAP
                    ?maintain           nil
                )

                gteShape5=rodCreateRect(
                    ?name               get_pname(concat("m2" "_" 2))
                    ?layer              list("Metal3" "drawing")
                    ?width              MW+(10-L)/1
                    ?length             ML
                )

                rodAlign(
                    ?alignObj           gteShape5
                    ?alignHandle        'centerCenter
                    ?refObj             rodGetObj(get_pname(concat("p" "_" 1)))
                    ?refHandle          'centerRight
                    ?xSep               minus(NDEXT+GAP+MW/2)
                    ?maintain           nil
                )

            ) ;end if

            for( i 2 fingers

                if( i<fingers then

                    gteShape6=rodCreateRect(
                        ?name               get_pname(concat("m2" "_" i+1))
                        ?layer              list("Metal3" "drawing")
                        ?width              MW+(10-L)/1
                        ?length             ML
                    )

                    rodAlign(
                        ?alignObj           gteShape6
                        ?alignHandle        'centerCenter
                        ?refObj             rodGetObj(get_pname(concat("p" "_" i)))
                        ?refHandle          'centerRight
                        ?xSep               minus(NDEXT+GAP+MW/2)
                        ?maintain           nil
                    )

                ) ;end if

                if( i==fingers then

                    gteShape7=rodCreateRect(
                        ?name               get_pname(concat("m2" "_" i+1))
                        ?layer              list("Metal3" "drawing")
                        ?width              MW+(10-L)/2
                        ?length             ML
                    )

                    rodAlign(
                        ?alignObj           gteShape7
                        ?alignHandle        'centerRight
                        ?refObj             rodGetObj(get_pname(concat("p" "_" i)))
                        ?refHandle          'centerRight
                        ?xSep               minus(NDEXT+GAP)
                        ?maintain           nil
                    )

                ) ;end if

            ) ;end for

            if( connectGates=="Top" then

                gteBBox = GTEcalculateFitBBox(
                    list((gteObj=rodGetObj(get_pname(concat("m1" "_" 1)))) && rodAddPoints(gteObj~>centerLeft list(0 W/2+GAP+PDEXT+5)) 'upperLeft)
                    list((gteObj=rodGetObj(get_pname(concat("m1" "_" fingers)))) && rodAddPoints(gteObj~>upperRight list(0 0)) 'lowerRight)
                ) ; GTEcalculateFitBBox

                when( gteBBox
                    gteShape8=rodCreateRect(
                        ?layer              list("Gate" "drawing")
                        ?bBox               gteBBox
                    )
                ) ; when gteBBox

            ) ;end if

            if( connectGates=="Bottom" then

                gteBBox = GTEcalculateFitBBox(
                    list((gteObj=rodGetObj(get_pname(concat("m1" "_" fingers)))) && rodAddPoints(gteObj~>lowerRight list(0 0)) 'upperRight)
                    list((gteObj=rodGetObj(get_pname(concat("m1" "_" 1)))) && rodAddPoints(gteObj~>centerLeft list(0 minus(W/2+GAP+PDEXT+5))) 'lowerLeft)
                ) ; GTEcalculateFitBBox

                when( gteBBox
                    gteShape9=rodCreateRect(
                        ?layer              list("Gate" "drawing")
                        ?bBox               gteBBox
                    )
                ) ; when gteBBox

            ) ;end if

            if( connectGates=="Alternate" then

                for( i 2 fingers

                    if( evenp(i) then

                        gteBBox = GTEcalculateFitBBox(
                            list((gteObj=rodGetObj(get_pname(concat("m1" "_" i-1)))) && rodAddPoints(gteObj~>centerLeft list(0 minus(W/2+GAP+PDEXT+5))) 'lowerLeft)
                            list((gteObj=rodGetObj(get_pname(concat("m1" "_" i)))) && rodAddPoints(gteObj~>lowerRight list(0 0)) 'upperRight)
                        ) ; GTEcalculateFitBBox

                        when( gteBBox
                            gteShape10=rodCreateRect(
                                ?layer              list("Gate" "drawing")
                                ?bBox               gteBBox
                            )
                        ) ; when gteBBox

                    ) ;end if

                    if( oddp(i) then

                        gteBBox = GTEcalculateFitBBox(
                            list((gteObj=rodGetObj(get_pname(concat("m1" "_" i)))) && rodAddPoints(gteObj~>upperRight list(0 0)) 'lowerRight)
                            list((gteObj=rodGetObj(get_pname(concat("m1" "_" i-1)))) && rodAddPoints(gteObj~>centerLeft list(0 W/2+GAP+PDEXT+5)) 'upperLeft)
                        ) ; GTEcalculateFitBBox

                        when( gteBBox
                            gteShape11=rodCreateRect(
                                ?layer              list("Gate" "drawing")
                                ?bBox               gteBBox
                            )
                        ) ; when gteBBox

                    ) ;end if

                ) ;end for

            ) ;end if

            if( connectSD then

                for( i 1 fingers+1

                    if( evenp(i) then

                        gteBBox = GTEcalculateFitBBox(
                            list((gteObj=rodGetObj(get_pname(concat("m2" "_" i)))) && rodAddPoints(gteObj~>lowerRight list(0 0)) 'upperRight)
                            list((gteObj=rodGetObj(get_pname(concat("m2" "_" i)))) && rodAddPoints(gteObj~>lowerLeft list(0 minus((W-ML)/2+PDEXT+GAP+5))) 'lowerLeft)
                        ) ; GTEcalculateFitBBox

                        when( gteBBox
                            gteShape12=rodCreateRect(
                                ?name               get_pname(concat("m2e" "_" i/2))
                                ?layer              list("Metal3" "drawing")
                                ?bBox               gteBBox
                            )
                        ) ; when gteBBox

                    ) ;end if

                    if( oddp(i) then

                        gteBBox = GTEcalculateFitBBox(
                            list((gteObj=rodGetObj(get_pname(concat("m2" "_" i)))) && rodAddPoints(gteObj~>upperRight list(0 (W-ML)/2+PDEXT+GAP+5)) 'upperRight)
                            list((gteObj=rodGetObj(get_pname(concat("m2" "_" i)))) && rodAddPoints(gteObj~>upperLeft list(0 0)) 'lowerLeft)
                        ) ; GTEcalculateFitBBox

                        when( gteBBox
                            gteShape13=rodCreateRect(
                                ?name               get_pname(concat("m2o" "_" (i+1)/2))
                                ?layer              list("Metal3" "drawing")
                                ?bBox               gteBBox
                            )
                        ) ; when gteBBox

                    ) ;end if

                ) ;end for

                if( evenp(fingers+1) then

                    gteBBox = GTEcalculateFitBBox(
                        list((gteObj=rodGetObj(get_pname(concat("m2e" "_" 1)))) && rodAddPoints(gteObj~>lowerLeft list(0 0)) 'upperLeft)
                        list((gteObj=rodGetObj(get_pname(concat("m2e" "_" (fingers+1)/2)))) && rodAddPoints(gteObj~>lowerRight list(0 minus(10))) 'lowerRight)
                    ) ; GTEcalculateFitBBox

                    when( gteBBox
                        gteShape14=rodCreateRect(
                            ?layer              list("Metal3" "drawing")
                            ?bBox               gteBBox
                        )
                    ) ; when gteBBox

                    gteBBox = GTEcalculateFitBBox(
                        list((gteObj=rodGetObj(get_pname(concat("m2o" "_" (fingers+1)/2)))) && rodAddPoints(gteObj~>upperRight list(0 10)) 'upperRight)
                        list((gteObj=rodGetObj(get_pname(concat("m2o" "_" 1)))) && rodAddPoints(gteObj~>upperLeft list(0 0)) 'lowerLeft)
                    ) ; GTEcalculateFitBBox

                    when( gteBBox
                        gteShape15=rodCreateRect(
                            ?layer              list("Metal3" "drawing")
                            ?bBox               gteBBox
                        )
                    ) ; when gteBBox

                ) ;end if

                if( oddp(fingers+1) then

                    gteBBox = GTEcalculateFitBBox(
                        list((gteObj=rodGetObj(get_pname(concat("m2e" "_" 1)))) && rodAddPoints(gteObj~>lowerLeft list(0 0)) 'upperLeft)
                        list((gteObj=rodGetObj(get_pname(concat("m2e" "_" fingers/2)))) && rodAddPoints(gteObj~>lowerRight list(0 minus(10))) 'lowerRight)
                    ) ; GTEcalculateFitBBox

                    when( gteBBox
                        gteShape16=rodCreateRect(
                            ?layer              list("Metal3" "drawing")
                            ?bBox               gteBBox
                        )
                    ) ; when gteBBox

                    gteBBox = GTEcalculateFitBBox(
                        list((gteObj=rodGetObj(get_pname(concat("m2o" "_" (fingers+2)/2)))) && rodAddPoints(gteObj~>upperRight list(0 10)) 'upperRight)
                        list((gteObj=rodGetObj(get_pname(concat("m2o" "_" 1)))) && rodAddPoints(gteObj~>upperLeft list(0 0)) 'lowerLeft)
                    ) ; GTEcalculateFitBBox

                    when( gteBBox
                        gteShape17=rodCreateRect(
                            ?layer              list("Metal3" "drawing")
                            ?bBox               gteBBox
                        )
                    ) ; when gteBBox

                ) ;end if

            ) ;end if

            for( i 1 fingers+1

                if( PasXor( evenp(i) switchSD) then

                    GTEaddIC6pin(cv rodGetObj(get_pname(concat("m2" "_" i)))~>dbId "D" "inputOutput" "right" list("top" "bottom" "left" "right") nil nil gteUniqueTermNum++)

                ) ;end if

                if( PasXor( oddp(i) switchSD) then

                    GTEaddIC6pin(cv rodGetObj(get_pname(concat("m2" "_" i)))~>dbId "S" "inputOutput" "left" list("top" "bottom" "left" "right") nil nil gteUniqueTermNum++)

                ) ;end if

            ) ;end for

            unless( mfgGrid techSetMfgGridResolution(tfId nil))
            t
        )
    )

    ;save db object
    if( dbIsId(gteDbId) then dbSave(gteDbId) dbClose(gteDbId)
    else error("unable to create pcell %s/%s/%s" gteLibName gteCellName gteViewName))
) ;end MoS2/Mo/layout definition
